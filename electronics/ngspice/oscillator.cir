.title Oscillator

.include ../models/BFP620.lib
.include ../models/SMV2019079LF.lib
.include ../models/10pf0402.lib

Vsupply VCC 0 PULSE(0 3.0 20p 5p 1p 1ms 1ms)

Lsupply VCC collector 440NH

X1 collector Base E1 E2 BFP620

LV1 Base Base_ 0.7NH
C1 Base_ 0 2p
LV2 collector collector_ 0.7NH
C2 collector_ 0 2p

Rbase_pulldown Base 0 10K //0 ohm link

Lem E1 E_ 440NH
Rem E_ E__ 100
Vem E__ 0 -2

Rem2 E1 E2 0

//X5 Base Varbias_2 SMV2019079LF
//X6 Varbias_2 0 10pf0402

//R6 Varbias_1 Vvaractor 20000
//R7 Varbias_2 Vvaractor 20000

.param varactor_bias_voltage = 15
Vcap Vvaractor 0 varactor_bias_voltage
//.ic v(Varbias_1) = varactor_bias_voltage
//.ic v(Varbias_2) = varactor_bias_voltage

.control

//set num_threads=8

setcs DIOgradingCoeffMax=3.0
setcs DIOtDepCapMax = 2.0
//tran 1p 100000ps uic
//uic?
//plot VCC Base
//plot collector
//plot b1 b2
//spec 0 15e9 3e7 v(collector)
//set specwindow = "blackman"
//plot mag(v(collector))
//set spectrum = mag(v(collector))

.endc

.end
